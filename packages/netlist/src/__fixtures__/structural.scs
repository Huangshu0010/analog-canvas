// Generated by Interactive Circuit Maker netlist-export/1.0
simulator lang=spectre
global VDD

subckt leaf (d g s b)
parameters scale=1
M1 (d g s b) nch l=60n w=2u
ends leaf

subckt top (vin vout)
C1 (vin vout) capacitor c=2p
D1 (vout 0) dmod area=2
I1 (VDD 0) isource dc=10u
L1 (vout 0) inductor l=3n
Q1 (vout vin 0) npnmod
R1 (vin vout) resistor r=10k temp=27
V1 (vin 0) vsource dc=1.2
X1 (vout vin 0 0) leaf scale=2
ends top
