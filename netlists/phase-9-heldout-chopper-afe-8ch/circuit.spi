* Phase 9 second held-out topology-only fixture.
* Eight-channel chopper analog front end; no simulation/performance claim.

.subckt chopper_channel INP INN CLK CLKB VBIAS OUTP OUTN VDD VSS
MSWP0 NXP CLK  INP VSS sky130_fd_pr__nfet_01v8 W=1.2u L=0.15u
MSWP1 NXP CLKB INN VSS sky130_fd_pr__nfet_01v8 W=1.2u L=0.15u
MSWN0 NXN CLK  INN VSS sky130_fd_pr__nfet_01v8 W=1.2u L=0.15u
MSWN1 NXN CLKB INP VSS sky130_fd_pr__nfet_01v8 W=1.2u L=0.15u
MINP  N1 NXP TAIL VSS sky130_fd_pr__nfet_01v8 W=4u L=0.5u
MINN  N2 NXN TAIL VSS sky130_fd_pr__nfet_01v8 W=4u L=0.5u
MTAIL TAIL VBIAS VSS VSS sky130_fd_pr__nfet_01v8 W=8u L=1u
MPC0  PC1 VBIAS VDD VDD sky130_fd_pr__pfet_01v8 W=6u L=0.5u
MPC1  PC2 VBIAS VDD VDD sky130_fd_pr__pfet_01v8 W=6u L=0.5u
MLOAD0 N1 N1 PC1 VDD sky130_fd_pr__pfet_01v8 W=6u L=0.5u
MLOAD1 N2 N1 PC2 VDD sky130_fd_pr__pfet_01v8 W=6u L=0.5u
MOUTP0 OUTP N1 VDD VDD sky130_fd_pr__pfet_01v8 W=10u L=0.3u
MOUTP1 OUTP N2 VSS VSS sky130_fd_pr__nfet_01v8 W=5u L=0.3u
MOUTN0 OUTN N2 VDD VDD sky130_fd_pr__pfet_01v8 W=10u L=0.3u
MOUTN1 OUTN N1 VSS VSS sky130_fd_pr__nfet_01v8 W=5u L=0.3u
MBIASP OUTP VBIAS VSS VSS sky130_fd_pr__nfet_01v8 W=2u L=1u
MBIASN OUTN VBIAS VSS VSS sky130_fd_pr__nfet_01v8 W=2u L=1u
MREF VBIAS VBIAS VSS VSS sky130_fd_pr__nfet_01v8 W=2u L=1u
.ends chopper_channel

.subckt chopper_afe_8ch CLK CLKB VBIAS VDD VSS
+ INP0 INN0 OUTP0 OUTN0 INP1 INN1 OUTP1 OUTN1
+ INP2 INN2 OUTP2 OUTN2 INP3 INN3 OUTP3 OUTN3
+ INP4 INN4 OUTP4 OUTN4 INP5 INN5 OUTP5 OUTN5
+ INP6 INN6 OUTP6 OUTN6 INP7 INN7 OUTP7 OUTN7
XCH0 INP0 INN0 CLK CLKB VBIAS OUTP0 OUTN0 VDD VSS chopper_channel
XCH1 INP1 INN1 CLK CLKB VBIAS OUTP1 OUTN1 VDD VSS chopper_channel
XCH2 INP2 INN2 CLK CLKB VBIAS OUTP2 OUTN2 VDD VSS chopper_channel
XCH3 INP3 INN3 CLK CLKB VBIAS OUTP3 OUTN3 VDD VSS chopper_channel
XCH4 INP4 INN4 CLK CLKB VBIAS OUTP4 OUTN4 VDD VSS chopper_channel
XCH5 INP5 INN5 CLK CLKB VBIAS OUTP5 OUTN5 VDD VSS chopper_channel
XCH6 INP6 INN6 CLK CLKB VBIAS OUTP6 OUTN6 VDD VSS chopper_channel
XCH7 INP7 INN7 CLK CLKB VBIAS OUTP7 OUTN7 VDD VSS chopper_channel
.ends chopper_afe_8ch

.end
