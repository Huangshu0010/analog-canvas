* Phase 9 third held-out topology-only fixture.
* Eight-stage fully differential feedback ring; no simulation/performance claim.

.subckt differential_delay_cell INP INN OUTP OUTN VBP VBN VDD VSS
MINP NDP INP TAIL VSS sky130_fd_pr__nfet_01v8 W=4u L=0.5u
MINN NDN INN TAIL VSS sky130_fd_pr__nfet_01v8 W=4u L=0.5u
MTAIL TAIL VBN VSS VSS sky130_fd_pr__nfet_01v8 W=8u L=1u
MLOADP NDP VBP VDD VDD sky130_fd_pr__pfet_01v8 W=6u L=0.5u
MLOADN NDN VBP VDD VDD sky130_fd_pr__pfet_01v8 W=6u L=0.5u
MREGENP NDP OUTN VDD VDD sky130_fd_pr__pfet_01v8 W=3u L=0.5u
MREGENN NDN OUTP VDD VDD sky130_fd_pr__pfet_01v8 W=3u L=0.5u
MOUTPP OUTP NDP VDD VDD sky130_fd_pr__pfet_01v8 W=8u L=0.3u
MOUTPN OUTP NDN VSS VSS sky130_fd_pr__nfet_01v8 W=4u L=0.3u
MOUTNP OUTN NDN VDD VDD sky130_fd_pr__pfet_01v8 W=8u L=0.3u
MOUTNN OUTN NDP VSS VSS sky130_fd_pr__nfet_01v8 W=4u L=0.3u
MBIASP VBP VBP VDD VDD sky130_fd_pr__pfet_01v8 W=2u L=1u
MBIASN VBN VBN VSS VSS sky130_fd_pr__nfet_01v8 W=2u L=1u
MTAILC TAIL VBN VSS VSS sky130_fd_pr__nfet_01v8 W=4u L=1u
.ends differential_delay_cell

.subckt differential_ring_8stage VBP VBN VDD VSS CLKP CLKN
XST0 CLKP CLKN P0 N0 VBP VBN VDD VSS differential_delay_cell
XST1 P0 N0 P1 N1 VBP VBN VDD VSS differential_delay_cell
XST2 P1 N1 P2 N2 VBP VBN VDD VSS differential_delay_cell
XST3 P2 N2 P3 N3 VBP VBN VDD VSS differential_delay_cell
XST4 P3 N3 P4 N4 VBP VBN VDD VSS differential_delay_cell
XST5 P4 N4 P5 N5 VBP VBN VDD VSS differential_delay_cell
XST6 P5 N5 P6 N6 VBP VBN VDD VSS differential_delay_cell
XST7 P6 N6 CLKP CLKN VBP VBN VDD VSS differential_delay_cell
.ends differential_ring_8stage

.end
